ADE simulation setup
Run mode: Single Run, Sweeps and Corners
Tests:
  VLSI_Arch_NG_Proposed_SEU_tolerent_FF_1: VLSI_Arch_NG/Proposed_SEU_tolerent_FF/schematic, simulator spectre
