ADE simulation setup
Test VLSI_Arch_NG_Proposed_SEU_tolerent_FF_1: VLSI_Arch_NG/Proposed_SEU_tolerent_FF/schematic, simulator spectre
  Models: /mnt/cadence_tools/gpdk045_v_6_0/gpdk045/../models/spectre/gpdk045.scs[mc]
  Temperature: 27
  Stimulus Vdd: voltage dc dc=1.25 srcType=dc
  Stimulus D: voltage pulse val0=0 val1=1.25 period=2n rise=1p fall=1p srcType=pulse
  Stimulus CK: voltage pulse val0=0 val1=1.25 period=1n delay=250p rise=1p fall=1p srcType=pulse
  Analysis tran: stop=10n
  Signals: /D, /CK, /N1, /N2, /N3, /N4, /N5, /Q
Run mode: Single Run, Sweeps and Corners
