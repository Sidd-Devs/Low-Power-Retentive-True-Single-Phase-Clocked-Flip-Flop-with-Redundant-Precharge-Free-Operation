ADE simulation setup
Test VLSI_Arch_NG_S2_CFF_1: VLSI_Arch_NG/S2_CFF/schematic, simulator spectre
  Models: /mnt/cadence_tools/gpdk180_v3.3/models/spectre/gpdk.scs[stat], /mnt/cadence_tools/gpdk045_v_6_0/gpdk045/../models/spectre/gpdk045.scs[mc]
  Temperature: 27
  Stimulus D: voltage pwl dc=1.2 pwlfilter=  abstime=  tvpairs=3 t1=0 v1=0 t2=149.989999n v2=0 t3=149.99n v3=1.2 v4=0 v5=0 v6=0 v7=0 v8=0 v9=0 v10=0 v11=0 v12=0 v13=0 v14=0 v15=0 v16=0 v17=0 v18=0 v19=0 v20=0 v21=0 v22=0 v23=0 v24=0 v25=0 v26=0 v27=0 v28=0 v29=0 v30=0 v31=0 v32=0 v33=0 v34=0 v35=0 v36=0 v37=0 v38=0 v39=0 v40=0 v41=0 v42=0 v43=0 v44=0 v45=0 v46=0 v47=0 v48=0 v49=0 v50=0 srcType=pwl
  Stimulus CK: voltage pulse val0=1.2 val1=0 period=100n rise=100.0000a fall=100.0000a srcType=pulse
  Analysis tran: stop=400n
  Output Power = average((VT("/Vdd") * IT("/V0/PLUS")))
  Output Delay = delay(?wf1 VT("/CK") ?value1 (0.5 * VAR("v")) ?edge1 "rising" ?nth1 2 ?td1 0.0 ?tol1 nil ?wf2 VT("/Q") ?value2 (0.5 * VAR("v")) ?edge2 "rising" ?nth2 1 ?tol2 nil ?td2 nil ?stop nil ?multiple nil) (unticked)
  Signals: /D, /CK, /N2, /Q, /Vdd, /V0/PLUS (terminal)
Run mode: Single Run, Sweeps and Corners
