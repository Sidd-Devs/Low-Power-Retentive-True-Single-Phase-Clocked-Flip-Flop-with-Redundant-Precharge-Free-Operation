ADE simulation setup
Run mode: Single Run, Sweeps and Corners
Tests:
  VLSI_Arch_NG_S2_CFF_1: VLSI_Arch_NG/S2_CFF/schematic, simulator spectre
    Outputs: Power
