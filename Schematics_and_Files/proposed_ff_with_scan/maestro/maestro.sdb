ADE simulation setup
Run mode: Single Run, Sweeps and Corners
Tests:
  VLSI_Arch_NG_proposed_ff_with_scan_1: VLSI_Arch_NG/proposed_ff_with_scan/schematic, simulator spectre
