ADE simulation setup
Test VLSI_Arch_NG_proposed_ff_with_scan_1: VLSI_Arch_NG/proposed_ff_with_scan/schematic, simulator spectre
  Models: /mnt/cadence_tools/gpdk180_v3.3/models/spectre/gpdk.scs[stat], /mnt/cadence_tools/gpdk045_v_6_0/gpdk045/../models/spectre/gpdk045.scs[mc]
  Temperature: 27
  Stimulus D: voltage pulse val0=1.25 val1=0 period=2n rise=1.000p fall=1.000p srcType=pulse
  Stimulus Vdd: voltage dc dc=1.25 srcType=dc
  Stimulus CK: voltage pulse val0=0 val1=1.25 period=1n delay=250p rise=1.000p fall=1.000p srcType=pulse
  Stimulus SE: voltage pulse val0=1.25 val1=0 period=16n delay=-1.375n rise=1p fall=1p srcType=pulse
  Stimulus SI: voltage pulse val0=1.25 val1=0 period=4n delay=1n rise=1p fall=1p srcType=pulse
  Analysis tran: stop=20n
  Signals: /D, /CK, /SI, /SE, /N1, /N2, /N3, /Q
Run mode: Single Run, Sweeps and Corners
