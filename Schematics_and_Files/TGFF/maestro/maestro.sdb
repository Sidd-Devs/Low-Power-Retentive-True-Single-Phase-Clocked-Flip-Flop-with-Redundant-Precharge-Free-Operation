ADE simulation setup
Run mode: Single Run, Sweeps and Corners
Tests:
  VLSI_Arch_NG_TGFF_1: VLSI_Arch_NG/TGFF/schematic, simulator spectre
    Outputs: Power; Delay
