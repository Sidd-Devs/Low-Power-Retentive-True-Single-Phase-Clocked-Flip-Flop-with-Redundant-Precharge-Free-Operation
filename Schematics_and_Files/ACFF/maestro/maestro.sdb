ADE simulation setup
Run mode: Single Run, Sweeps and Corners
Tests:
  VLSI_Arch_NG_ACFF_1: VLSI_Arch_NG/ACFF/schematic, simulator spectre
    Outputs: Power
