ADE simulation setup
Run mode: Single Run, Sweeps and Corners
Tests:
  VLSI_Arch_NG_Proposed_FF_with_reset_1: VLSI_Arch_NG/Proposed_FF_with_reset/schematic, simulator spectre
