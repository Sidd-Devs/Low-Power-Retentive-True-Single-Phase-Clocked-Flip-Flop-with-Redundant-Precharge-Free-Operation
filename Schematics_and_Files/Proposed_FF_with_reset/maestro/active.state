ADE simulation setup
Test VLSI_Arch_NG_Proposed_FF_with_reset_1: VLSI_Arch_NG/Proposed_FF_with_reset/schematic, simulator spectre
  Models: /mnt/cadence_tools/gpdk180_v3.3/models/spectre/gpdk.scs[stat], /mnt/cadence_tools/gpdk045_v_6_0/gpdk045/../models/spectre/gpdk045.scs[mc]
  Temperature: 27
  Stimulus D: voltage pulse val0=0 val1=1.25 period=2n rise=1.000p fall=1.000p srcType=pulse
  Stimulus Vdd: voltage dc dc=1.25 srcType=dc
  Stimulus CK: voltage pulse val0=0 val1=1.25 period=1n delay=250.00p rise=1.000p fall=1.000p srcType=pulse
  Stimulus RSTN: voltage pulse val0=1.25 val1=0 period=7n delay=2.6n rise=1.000p fall=1.000p srcType=pulse
  Analysis tran: stop=10n
  Signals: /D, /CK, /Q
Run mode: Single Run, Sweeps and Corners
