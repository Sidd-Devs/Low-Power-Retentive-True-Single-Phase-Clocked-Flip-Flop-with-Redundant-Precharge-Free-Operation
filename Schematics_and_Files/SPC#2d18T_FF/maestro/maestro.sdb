ADE simulation setup
Run mode: Single Run, Sweeps and Corners
Tests:
  VLSI_Arch_NG_SPC-18T_FF_1: VLSI_Arch_NG/SPC-18T_FF/schematic, simulator spectre
    Outputs: Power
