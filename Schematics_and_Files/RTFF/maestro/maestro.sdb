ADE simulation setup
Run mode: Single Run, Sweeps and Corners
Tests:
  VLSI_Arch_NG_RTFF_1: VLSI_Arch_NG/RTFF/schematic, simulator spectre
    Outputs: Power
