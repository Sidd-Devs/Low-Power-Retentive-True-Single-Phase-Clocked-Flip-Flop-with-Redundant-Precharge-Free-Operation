ADE simulation setup
Run mode: Single Run, Sweeps and Corners
Tests:
  VLSI_Arch_NG_TCFF_1: VLSI_Arch_NG/TCFF/schematic, simulator spectre
