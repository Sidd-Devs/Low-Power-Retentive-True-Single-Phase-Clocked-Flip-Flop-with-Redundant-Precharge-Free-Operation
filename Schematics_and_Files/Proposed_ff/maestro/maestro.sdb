ADE simulation setup
Run mode: Single Run, Sweeps and Corners
Tests:
  VLSI_Arch_NG_Proposed_ff_1: VLSI_Arch_NG/Proposed_ff/schematic, simulator spectre
    Outputs: Power
