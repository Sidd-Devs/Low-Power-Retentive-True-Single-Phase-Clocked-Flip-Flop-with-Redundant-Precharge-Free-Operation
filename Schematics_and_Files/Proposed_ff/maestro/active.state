ADE simulation setup
Test VLSI_Arch_NG_Proposed_ff_1: VLSI_Arch_NG/Proposed_ff/schematic, simulator spectre
  Models: /mnt/cadence_tools/gpdk180_v3.3/models/spectre/gpdk.scs[stat], /mnt/cadence_tools/gpdk045_v_6_0/gpdk045/../models/spectre/gpdk045.scs[mc]
  Temperature: 27
  Stimulus D: voltage dc dc=600.0m srcType=dc
  Stimulus CK: voltage pulse val0=600.0m val1=0 period=100n rise=100p fall=100p srcType=pulse
  Analysis tran: stop=1000n
  Output Power = average((IT("/V0/PLUS") * VT("/Vdd")))
  Output Delay_f = delay(?wf1 VT("/CK") ?value1 (0.5 * VAR("v")) ?edge1 "rising" ?nth1 2 ?td1 0.0 ?tol1 nil ?wf2 VT("/Q") ?value2 (0.5 * VAR("v")) ?edge2 "rising" ?nth2 1 ?tol2 nil ?td2 nil ?stop nil ?multiple nil) (unticked)
  Signals: /Vdd, /V0/PLUS (terminal), /D, /CK, /Q
Run mode: Single Run, Sweeps and Corners
